# Ansys Electronics Desktop project, version 2025.2
materials:
  vacuum: permittivity=1
  pec: conductivity=1e+30

design HFSSDesign1 (HFSS, SBR+, model units meter)
options: Allow_Material_Override
geometry:
  AGM88 [pec] = imported_body(D:\ansysdev\PyAEDT\projects\Missle.sat)
  AGM88.rotate(axis=Z, angle=-90deg)
boundaries and excitations:
  IncPWave1: Plane Incident Wave PhiStart=225deg PhiStop=315deg PhiPoints=181 ThetaStart=90deg ThetaStop=90deg ThetaPoints=1 EoPhi=0 EoTheta=-1 OriginX=0mm OriginY=-2.5meter OriginZ=0mm IsPropagating
mesh:
  initial mesh: GlobalSurfApproximation{CurvedSurfaceApproxChoice=UseSlider SliderMeshSettings=7}
setups:
  SBR: HfssDriven ComputeFields RayDensityPerWavelength=4 MaxNumberOfBounces=3 IsMonostaticRCS PTDUTDSimulationSettings=None CWRaySampleDensity=10 CWRayCutoffDb=40 CWCurvatureSensitivity=50 CWAngularRayInterval=2
    sweep Sweep: point 1GHz;
source amplitudes:
  IncPWave1:1: 1 0deg
